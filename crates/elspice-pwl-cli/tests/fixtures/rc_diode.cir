V1 a 0 5
D1 a b dmodel
R1 b c 1
C1 c 0 1
